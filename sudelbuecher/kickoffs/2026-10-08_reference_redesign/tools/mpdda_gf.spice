.subckt d2s_mpdda vdd vss vddo vsso vinp vinn vref vout vfb vbp vbn vbpc vbnc vabp vabn wc=16u lc=16u rl=50u
XA x y vinp vref vdd vss vbp unit_r2 rl={rl}
XB x y vref vinn vdd vss vbp unit_r2 rl={rl}
XC1 x y vref vfb vdd vss vbp unit_r2 rl={rl}
XC2 x y vref vfb vdd vss vbp unit_r2 rl={rl}
XSX x vbn vss vss nfet_03v3 W=36u L=6u nf=4
XSY y vbn vss vss nfet_03v3 W=36u L=6u nf=4
XCX l1 vbnc x vss nfet_03v3 W=30u L=3u nf=2
XCY b vbnc y vss nfet_03v3 W=30u L=3u nf=2
XPL pl l2 vdd vdd pfet_03v3 W=24u L=4u nf=4
XPR pr l2 vdd vdd pfet_03v3 W=24u L=4u nf=4
XPCL l2 vbpc pl vdd pfet_03v3 W=30u L=3u nf=2
XPCR a vbpc pr vdd pfet_03v3 W=30u L=3u nf=2
XFPL l1 vabp l2 vdd pfet_03v3 W=6.66u L=0.6u nf=1
XFNL l2 vabn l1 vss nfet_03v3 W=4.4u L=1u nf=1
XABP b vabp a vdd pfet_03v3 W=6.66u L=0.6u nf=1
XABN a vabn b vss nfet_03v3 W=4.4u L=1u nf=1
XOP vout a vddo vddo pfet_03v3 W=91.02u L=0.6u nf=14 m=6
XON vout b vsso vsso nfet_03v3 W=96.8u L=1u nf=22 m=3
XCMA vout a vout vout pfet_03v3 W={wc} L={lc} nf=1
XCMB b vout b b pfet_03v3 W={wc} L={lc} nf=1
.ends d2s_mpdda
