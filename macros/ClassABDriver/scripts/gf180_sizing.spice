* GF180MCU 03v3 sizing netlists of the class-AB driver and its bias, 2026-10-08 (source of the port)
* unit_r2 for GF180 03v3: split-tail PMOS pair, ppolyf_u_3k between the sources
.subckt unit_r2 x y gp gn vdd vss vbp
XTa sa vbp vdd vdd pfet_03v3 W=20u L=6u nf=2
XTb sb vbp vdd vdd pfet_03v3 W=20u L=6u nf=2
XR sa sb vss ppolyf_u_3k r_width=1u r_length=50u
XMa y gp sa sa pfet_03v3 W=20u L=1u nf=2
XMb x gn sb sb pfet_03v3 W=20u L=1u nf=2
.ends unit_r2
.subckt d2s_bias_lp vdd vss vddo vsso vbp vbn vbpc vbnc vabp vabn iab=5u ibnc=2u
IBP vbp vss 5u
XBP vbp vbp vdd vdd pfet_03v3 W=20u L=6u nf=2
IBN vdd vbn 5u
XBN vbn vbn vss vss nfet_03v3 W=6u L=6u nf=1
IBNC vdd vbnc {ibnc}
XBNC vbnc vbnc vss vss nfet_03v3 W=1u L=8u nf=1
IBPC vbpc vss 2u
XBPC vbpc vbpc vdd vdd pfet_03v3 W=1u L=4u nf=1
IABP vabp vss {iab}
XRP1 n1 n1 vddo vddo pfet_03v3 W=12u L=0.6u nf=2
XRP2 vabp vabp n1 vdd pfet_03v3 W=6.66u L=0.6u nf=1
IABN vdd vabn {iab}
XRN1 n2 n2 vsso vsso nfet_03v3 W=8u L=1u nf=2
XRN2 vabn vabn n2 vss nfet_03v3 W=4.4u L=1u nf=1
.ends d2s_bias_lp
.subckt d2s_mpdda vdd vss vddo vsso vinp vinn vref vout vfb vbp vbn vbpc vbnc vabp vabn
XA x y vinp vref vdd vss vbp unit_r2
XB x y vref vinn vdd vss vbp unit_r2
XC1 x y vref vfb vdd vss vbp unit_r2
XC2 x y vref vfb vdd vss vbp unit_r2
XSX x vbn vss vss nfet_03v3 W=36u L=6u nf=4
XSY y vbn vss vss nfet_03v3 W=36u L=6u nf=4
XCX l1 vbnc x vss nfet_03v3 W=30u L=3u nf=2
XCY b vbnc y vss nfet_03v3 W=30u L=3u nf=2
XPL pl l2 vdd vdd pfet_03v3 W=24u L=4u nf=4
XPR pr l2 vdd vdd pfet_03v3 W=24u L=4u nf=4
XPCL l2 vbpc pl vdd pfet_03v3 W=30u L=3u nf=2
XPCR a vbpc pr vdd pfet_03v3 W=30u L=3u nf=2
XFPL l1 vabp l2 vdd pfet_03v3 W=6.66u L=0.6u nf=1
XFNL l2 vabn l1 vss nfet_03v3 W=4.4u L=1u nf=1
XABP b vabp a vdd pfet_03v3 W=6.66u L=0.6u nf=1
XABN a vabn b vss nfet_03v3 W=4.4u L=1u nf=1
XOP vout a vddo vddo pfet_03v3 W=91.02u L=0.6u nf=14 m=6
XON vout b vsso vsso nfet_03v3 W=96.8u L=1u nf=22 m=3
XCMA vout a vout vout pfet_03v3 W=16u L=16u nf=1
XCMB b vout b b pfet_03v3 W=16u L=16u nf=1
.ends d2s_mpdda
* GF180 03v3 port of d2s_bias_ref.spice (diodes, in, out); sizes re-derived 2026-10-08
.subckt d2s_bias_diodes vdd vss vddo vsso vbp vbn vbpc vbnc vabp vabn
XBP vbp vbp vdd vdd pfet_03v3 W=20u L=6u nf=2
XBN vbn vbn vss vss nfet_03v3 W=6u L=6u nf=1
XBNC vbnc vbnc vss vss nfet_03v3 W=1u L=8u nf=1
XBPC vbpc vbpc vdd vdd pfet_03v3 W=1u L=4u nf=1
XRP1 n1 n1 vddo vddo pfet_03v3 W=12u L=0.6u nf=2
XRP2 vabp vabp n1 vdd pfet_03v3 W=6.66u L=0.6u nf=1
XRN1 n2 n2 vsso vsso nfet_03v3 W=8u L=1u nf=2
XRN2 vabn vabn n2 vss nfet_03v3 W=4.4u L=1u nf=1
.ends d2s_bias_diodes
.subckt d2s_bias_in vdd vss vddo vsso iref vbp vbn vbpc vbnc vabp vabn
XNI iref iref vss vss nfet_03v3 W=6u L=6u nf=1
XNBP vbp iref vss vss nfet_03v3 W=6u L=6u nf=1
XNBPC vbpc iref vss vss nfet_03v3 W=2.5u L=6u nf=1
XNABP vabp iref vss vss nfet_03v3 W=6u L=6u nf=1
XPBN vbn vbp vdd vdd pfet_03v3 W=20u L=6u nf=2
XPBNC vbnc vbp vdd vdd pfet_03v3 W=8u L=6u nf=1
XPABN vabn vbp vdd vdd pfet_03v3 W=20u L=6u nf=2
Xd vdd vss vddo vsso vbp vbn vbpc vbnc vabp vabn d2s_bias_diodes
.ends d2s_bias_in
.subckt d2s_bias_out vdd vss vddo vsso iref vbp vbn vbpc vbnc vabp vabn
XPI iref iref vdd vdd pfet_03v3 W=20u L=6u nf=2
XPBN vbn iref vdd vdd pfet_03v3 W=20u L=6u nf=2
XPBNC vbnc iref vdd vdd pfet_03v3 W=8u L=6u nf=1
XPABN vabn iref vdd vdd pfet_03v3 W=20u L=6u nf=2
XNBP vbp vbn vss vss nfet_03v3 W=6u L=6u nf=1
XNBPC vbpc vbn vss vss nfet_03v3 W=2.5u L=6u nf=1
XNABP vabp vbn vss vss nfet_03v3 W=6u L=6u nf=1
Xd vdd vss vddo vsso vbp vbn vbpc vbnc vabp vabn d2s_bias_diodes
.ends d2s_bias_out
