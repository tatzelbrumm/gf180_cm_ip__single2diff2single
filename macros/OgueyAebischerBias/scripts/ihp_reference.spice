* Topology of the IHP sg13cmos5l OgueyAebischerBias macro (reference.spice of RUN_2026-09-04, CACE netlist),
* used by check_port.py as the source of truth for the GF180 port. Device sizes here are the IHP ones.
.subckt OgueyAebischerBias vdd vbp vbn vbr vss
XM10 net3 vbn vres vss sg13_hv_nmos w=1u l=1u ng=1 m=4 mm_ok=1
XM12 vbp vbp vdd vdd sg13_hv_pmos w=1u l=1u ng=1 m=1 mm_ok=1
XM11 vbn vbn vss vss sg13_hv_nmos w=1u l=1u ng=1 m=1 mm_ok=1
XM13 net2 vbp vdd vdd sg13_hv_pmos w=1u l=1u ng=1 m=4 mm_ok=1
XM14 net1 vbp vdd vdd sg13_hv_pmos w=1u l=1u ng=1 m=2 mm_ok=1
XM16 vres vbr net5 vss sg13_hv_nmos w=1u l=20u ng=1 m=1 mm_ok=1
XM15 vbr vbr net4 vss sg13_hv_nmos w=1u l=20u ng=1 m=1 mm_ok=1
Vi1 vbp net3 0
Vi4 net2 vbn 0
Viaux net1 vbr 0
XM18 net5 vbr net6 vss sg13_hv_nmos w=1u l=20u ng=1 m=1 mm_ok=1
XM17 net4 vbr net7 vss sg13_hv_nmos w=1u l=20u ng=1 m=1 mm_ok=1
XM20 net6 vbr net9 vss sg13_hv_nmos w=1u l=20u ng=1 m=1 mm_ok=1
XM19 net7 vbr net8 vss sg13_hv_nmos w=1u l=20u ng=1 m=1 mm_ok=1
XM22 net9 vbr vss vss sg13_hv_nmos w=1u l=20u ng=1 m=1 mm_ok=1
XM21 net8 vbr vss vss sg13_hv_nmos w=1u l=20u ng=1 m=1 mm_ok=1
.ends
.subckt ToBiasStartup vdd vbp vbn disable vbr vss
XM24 vbr disable vss vss sg13_hv_nmos w=1u l=0.45u ng=1 m=1 mm_ok=1
XM22 vbr vkick vdd vdd sg13_hv_pmos w=1u l=0.45u ng=1 m=1 mm_ok=1
XM25 vkick vbp vdd vdd sg13_hv_pmos w=1u l=0.45u ng=1 m=1 mm_ok=1
XM23 vbn disable vss vss sg13_hv_nmos w=1u l=0.45u ng=1 m=1 mm_ok=1
XM21 vbn vkick vdd vdd sg13_hv_pmos w=1u l=0.45u ng=1 m=1 mm_ok=1
XM20 disable vkick disable vss sg13_hv_nmos w=8u l=2u ng=1 m=1 mm_ok=1
XM26 vdd vbp vdd vss sg13_hv_nmos w=8u l=2u ng=1 m=1 mm_ok=1
.ends
.subckt reference vdd vbp vbn disable vbr vss
xbias vdd vbp vbn vbr vss OgueyAebischerBias
xstart vdd vbp vbn disable vbr vss ToBiasStartup
.ends
